`include "discipline.h"
`include "constants.h"
`include "VAMS_symbols.vams"

`timescale 1ns/1ps

module cp_ams(
    up,
    down,
    fout,
    vsrc
  );
    input up; electrical up;
    input down; electrical down;
    inout fout; electrical fout;
    inout vsrc; electrical vsrc;

    electrical vout;

    charge_pump cp1(up, down, vout, vsrc);
    cap#(.c(5p)) c1(vout, gnd);
    res#(.r(50)) r1(vout, fout);
    cap#(.c(50p)) c2(fout, gnd);

endmodule
