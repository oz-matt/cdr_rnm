`ifndef VAMS_SYMBOLS_GUARD
`define VAMS_SYMBOLS_GUARD

`include "EVsrcG.vams"
`include "CPUMP_wreal.vams"

`endif
