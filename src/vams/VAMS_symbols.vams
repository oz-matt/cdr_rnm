`ifndef VAMS_SYMBOLS_GUARD
`define VAMS_SYMBOLS_GUARD

`include "EVsrcG.vams"
`include "CPUMP_wreal.vams"
`include "charge_pump.va"
`include "cp_ams.vams"
`include "cap.vams"
`include "res.va"

`endif
