`include "discipline.h"
`include "constants.h"

module cap(vp, vn);
inout vp, vn;
wreal vp, vn;
electrical vpe, vne;
parameter real c = 0;

   analog begin

     V(vpe, vne) <+ (vp-vn);

     I(vpe, vne) <+ ddt(c*V(vpe, vne));

   end

endmodule
