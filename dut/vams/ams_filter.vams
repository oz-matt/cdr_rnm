`include "discipline.h"
`include "constants.h"

module ams_filter(in, out);

  input in;
  output out;

  electrical in, out;

  parameter real r = 1e3 from (0:inf);
  parameter real c = 1e-12 from (0:inf);

  //electrical in_transitioned;

  analog begin
    //V(in_transitioned) <+ transition(V(in), 0, 200n, 200n);
    V(out) <+ laplace_nd(V(in), {1}, {-10000, 0});
  end

endmodule
