`include "discipline.h"
`include "constants.h"

module cap(vp, vn);
inout vp, vn;
electrical vp, vn;
parameter real c = 1p;

   analog
      I(vp, vn) <+ ddt(c*V(vp, vn));
endmodule
