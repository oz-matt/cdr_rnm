`include "discipline.h"
`include "constants.h"

(* instrument_module *)
module ams_cp(siginc, sigdec, vout, vsrc);
input siginc, sigdec;
inout vout, vsrc;
electrical siginc, sigdec, vout, vsrc;
parameter real iamp=0.5m from [0:inf);
parameter real vtrans = 2.5;
parameter real tdel=0 from [0:inf);
parameter real trise=1n from (0:inf);
parameter real tfall=1n from (0:inf);

   real iout_val;

   //
   // Current multiplier - returns direction that charge should be pumped
   //
   analog function real i_mult;
   input inc;
   input dec;
   input vtrans;
   real inc;
   real dec;
   real vtrans;

      integer inc_high;
      integer dec_high;

   begin
      inc_high = inc > vtrans;
      dec_high = dec > vtrans;
      i_mult = 0.0;
      if (inc_high == dec_high) begin
         i_mult = 0.0;
      end else if (inc_high) begin
         i_mult = 1.0;
      end else if (dec_high) begin
         i_mult = -1.0;
      end
   end
   endfunction

   analog begin
      @ ( initial_step ) begin
	 iout_val = iamp*i_mult(V(siginc), V(sigdec), vtrans);
      end

      @ (cross(V(siginc) - vtrans, 0)) begin
         iout_val = iamp*i_mult(V(siginc),V(sigdec),vtrans);
      end
      @ (cross(V(sigdec) - vtrans, 0)) begin
         iout_val = iamp //* (V(vout) > 0.01) /*Only allow current draw from load if it has positive voltage*/
         * i_mult(V(siginc),V(sigdec),vtrans);
      end

      I(vsrc, vout) <+ transition(iout_val,tdel,trise,tfall);
   end
endmodule
